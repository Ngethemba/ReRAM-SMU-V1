* Test I - Filament-like transition energy 1us
* Same circuit as 10us but Trise=1us

.param Vsrc=2
.param Rsense=500
.param Riso=47
.param Rs=547
.param Cdown=150p
.param Rhrs=1e6
.param Rlrs=1e3
.param Trise=1u
.param t0=5u
.param Ilim=100u
.param Vthr=50m

E1 src_eff 0 value={ V(del) > 2.5 ? ( V(dut) + 100u*547 ) : 2.0 }

Rsense src_eff s1 500
Riso   s1 dut 47
Cdown dut 0 150p

Bdut dut 0 I = V(dut) / (1e6 + (1e3-1e6)*min(max((time-5u)/1u,0),1))

Ecomp comp 0 value={ (V(src_eff,s1) - 50m) > 0 ? 5 : 0 }
Rdel comp del 10k
Cdel del 0 400p
.ic V(del)=0

Vraw vraw 0 DC 2
Rs2 vraw s1b 500
Riso2 s1b dut2 47
C2 dut2 0 150p
Bdut2 dut2 0 I = V(dut2) / (1e6 + (1e3-1e6)*min(max((time-5u)/1u,0),1))

.options gmin=1e-12 abstol=1e-12 reltol=0.001

.control
tran 0.02u 30u uic
wrdata simulation/phase3/compliance/test_I_1us_wr.dat v(dut) v(dut2) v(src_eff) v(del)
write simulation/phase3/compliance/test_I_1us.raw v(dut) v(dut2) v(del)
.endc

.end
