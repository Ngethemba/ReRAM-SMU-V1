* Test I - Filament-like transition energy 10us and 1us
* Topology: src_eff -> Rsense(500) -> Riso(47) -> dut -> C + Rdut(t)
* Rdut 1M->1k linear over Trise, starting at t0=5us
* LT1970A behavioral limit: Vthr 50mV, RC delay 4us

.param Vsrc=2
.param Rsense=500
.param Riso=47
.param Rs=547
.param Cdown=150p
.param Rhrs=1e6
.param Rlrs=1e3
.param Trise=10u
.param t0=5u
.param Ilim=100u
.param Vthr=50m

* Effective source with foldback (E1)
E1 src_eff 0 value={ V(del) > 2.5 ? ( V(dut) + 100u*547 ) : 2.0 }

Rsense src_eff s1 500
Riso   s1 dut 47
Cdown dut 0 150p

* DUT behavioral current: R(t) = Rhrs + (Rlrs-Rhrs)*clamp((time-t0)/Trise)
Bdut dut 0 I = V(dut) / (1e6 + (1e3-1e6)*min(max((time-5u)/10u,0),1))

* Comparator
Ecomp comp 0 value={ (V(src_eff,s1) - 50m) > 0 ? 5 : 0 }
Rdel comp del 10k
Cdel del 0 400p
.ic V(del)=0

* Unlimited reference branch (no limiter)
Vraw vraw 0 DC 2
Rs2 vraw s1b 500
Riso2 s1b dut2 47
C2 dut2 0 150p
Bdut2 dut2 0 I = V(dut2) / (1e6 + (1e3-1e6)*min(max((time-5u)/10u,0),1))

.options gmin=1e-12 abstol=1e-12 reltol=0.001

.control
tran 0.05u 60u uic
wrdata simulation/phase3/compliance/test_I_10us_wr.dat v(dut) v(dut2) v(src_eff) v(del) v(del) v(comp)
write simulation/phase3/compliance/test_I_10us.raw v(dut) v(dut2) v(del)
.endc

.end
