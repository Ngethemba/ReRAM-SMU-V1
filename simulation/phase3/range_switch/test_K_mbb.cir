* Test K - Range switching faults: hot-switch glitch vs safe BBM (MBB variant)
* MBB: S2 closes 1us BEFORE S1 opens => 2us overlap (make-before-break fault)
.title TestK MBB

.param R1=2.5
.param R2=25
.param Rdut=1k

Vsrc src 0 DC 2
Rdut src shunt_hi 1k
S1 shunt_hi g1 0 0 SW
S2 shunt_hi g2 0 0 SW
Rsh1 g1 0 2.5
Rsh2 g2 0 25
.model SW SW(Ron=0.1 Roff=1G Vt=2.5 Vh=0.2)

* MBB timing: Vg2 rises at 9us, Vg1 falls at 10us => overlap
Vg1 g1 0 PWL(0 5 9.9u 5 10u 0 30u 0)
Vg2 g2 0 PWL(0 0 9u 0 9.1u 5 30u 5)

.options gmin=1e-12

.control
tran 0.05u 30u uic
wrdata simulation/phase3/range_switch/test_K_mbb2_wr.dat v(shunt_hi) v(g1) v(g2)
write simulation/phase3/range_switch/test_K_mbb2.raw v(shunt_hi)
.endc
.end
