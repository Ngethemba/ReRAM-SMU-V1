* R5.1E GATE-E vendor LT1970 + REAL OPA140 K1 Kelvin diff - R5p1E_0p1V_CV_100R_100p_R47_CC10mA
* Vset 0.1V Rdut 100 Cdut 100p Riso 47 shunt 2.5 Vc 0.25
V1 VEE 0 -12
V2 VMINUS 0 -12
V3 VCC 0 12
V4 VPLUS 0 12
Vset IN 0 PULSE(0 0.1 1u 0.1u 0.1u 30u 60u)
Vcsrc VCSRC 0 0.25
Vcsnk VCSNK 0 0.25
Vcom COM 0 0
Ven EN 0 5
* Power path: OUT -> Riso -> FORCE_HI -> DUT//Cdut -> FORCE_LO -> Rshunt -> GND
Riso OUT FORCE_HI 47
Rdut FORCE_HI FORCE_LO 100
Cdut FORCE_HI FORCE_LO 100p
Rshunt FORCE_LO 0 2.5
Cshunt FORCE_LO 0 10p
* LT1970 senses low-side shunt Kelvin: SENSE+ = FORCE_LO, SENSE- = GND (0)
* Filter open baseline
* Real Kelvin: SENSE_HI_BUF from FORCE_HI, SENSE_LO_BUF from FORCE_LO -> diff -> VDIFF -> LT1970 -IN
* Buffers: OPAx140 followers
XBUF_HI FORCE_HI BUF_HI VCC VEE BUF_HI OPAx140
XBUF_LO FORCE_LO BUF_LO VCC VEE BUF_LO OPAx140
* Diff amp: 10k 0.1% 4-resistor, gain 1, C across feedback 15p
R1 BUF_LO N_DIFF_N 10k
R2 N_DIFF_N VDIFF 10k
R3 BUF_HI N_DIFF_P 10k
R4 N_DIFF_P 0 10k
Ccomp N_DIFF_N VDIFF 15p
XDIFF N_DIFF_P N_DIFF_N VCC VEE VDIFF OPAx140
* LT1970 instantiation - 19 nodes: VEE VMINUS OUT SENSEP FILTER SENSEM VCC -IN +IN NC10 NC11 VCSNK VCSRC COM EN ISRC ISNK NC18 VPLUS
* We map SENSEP=FORCE_LO, SENSEM=0, FILTER=open, -IN=VDIFF, +IN=IN
XU1 VEE VMINUS OUT FORCE_LO FILTER 0 VCC VDIFF IN NC10 NC11 VCSNK VCSRC COM EN N_ISRC N_ISNK NC18 VPLUS LT1970
Risrc N_ISRC 0 10k
Risnk N_ISNK 0 10k
Rnc10 NC10 0 1Meg
Rnc11 NC11 0 1Meg
Rnc18 NC18 0 1Meg
.lib "E:/ReRAM-SMU V1/simulation/phase3/opa140_model/OPAx140.LIB"
.lib "C:/Users/azrai/AppData/Local/LTspice/lib/sub/LT1970.sub"
.tran 0 80u 0 10n
.options gmin=1e-12 abstol=1e-12 reltol=0.001
.meas tran Vpeak MAX V(FORCE_HI,FORCE_LO) FROM 0 TO 80u
.meas tran Vfinal AVG V(FORCE_HI,FORCE_LO) FROM 10u TO 25u
.meas tran Vmin MIN V(FORCE_HI,FORCE_LO) FROM 0 TO 80u
.meas tran Overshoot PARAM (Vpeak-Vfinal)/abs(Vfinal+1e-12)*100
.meas tran Iplateau AVG I(Rshunt) FROM 10u TO 25u
.meas tran Vshunt AVG V(FORCE_LO) FROM 10u TO 25u
.meas tran Ipeak MAX I(Rshunt) FROM 0 TO 80u
.meas tran Vdut_final AVG V(FORCE_HI,FORCE_LO) FROM 10u TO 25u
.meas tran Vbuf_HI AVG V(BUF_HI) FROM 10u TO 25u
.meas tran Vbuf_LO AVG V(BUF_LO) FROM 10u TO 25u
.meas tran Vdiff_avg AVG V(VDIFF) FROM 10u TO 25u
.backanno
.end
