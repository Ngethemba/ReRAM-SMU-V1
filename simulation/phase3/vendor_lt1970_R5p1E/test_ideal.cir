* ideal diff no buffers
V1 VEE 0 -12
V2 VMINUS 0 -12
V3 VCC 0 12
V4 VPLUS 0 12
Vset IN 0 PULSE(0 2 1u 0.1u 0.1u 30u 60u)
Vcsrc VCSRC 0 5
Vcsnk VCSNK 0 5
Vcom COM 0 0
Ven EN 0 5
Riso OUT FORCE_HI 47
Rdut FORCE_HI FORCE_LO 10k
Cdut FORCE_HI FORCE_LO 100p
Rshunt FORCE_LO 0 500
Cshunt FORCE_LO 0 10p
Ediff NDIF 0 FORCE_HI FORCE_LO 1
Rpole NDIF VDIFF 1k
Cpole VDIFF 0 15p
XU1 VEE VMINUS OUT FORCE_LO FILTER 0 VCC VDIFF IN NC10 NC11 VCSNK VCSRC COM EN N_ISRC N_ISNK NC18 VPLUS LT1970
Risrc N_ISRC 0 10k
Risnk N_ISNK 0 10k
Rnc10 NC10 0 1Meg
Rnc11 NC11 0 1Meg
Rnc18 NC18 0 1Meg
.lib "C:/Users/azrai/AppData/Local/LTspice/lib/sub/LT1970.sub"
.tran 0 80u 0 10n
.meas tran Vfinal AVG V(FORCE_HI,FORCE_LO) FROM 10u TO 25u
.meas tran Vdiff_avg AVG V(VDIFF) FROM 10u TO 25u
.meas tran Iplateau AVG I(Rshunt) FROM 10u TO 25u
.backanno
.end
